* NOTE: written for ngspice (ngspice -b file.cir). If using LTspice instead,
* delete the ".control" / "run" / "plot ..." / ".endc" lines -- LTspice runs
* .tran automatically and you view traces from its waveform viewer.
*
* ===================================================================
* AUTOMATIC STREETLIGHT LDR HYSTERESIS COMPARATOR (behavioral)
* ===================================================================
* Purpose: validates dusk/dawn switching with hysteresis so the
* streetlight zone doesn't flicker at the twilight threshold when
* ambient light fluctuates slightly (clouds, passing shadows).
*
* The LDR + fixed-resistor divider is approximated here as a direct
* PWL voltage source on node "sense" (bright ~3.0V, dark ~0.3V) so the
* file runs without needing an LDR SPICE model. On the real board this
* node is the midpoint of an LDR/fixed-resistor divider off a 3.3V rail.
* ===================================================================

Vcc vcc 0 DC 3.3

* Ambient light stimulus: bright -> dark -> bright
Vlight sense 0 PWL(0 3.0 3 0.3 6 0.3 9 3.0 12 3.0)

* Reference + positive-feedback network -> node "ref"
Vref vref0 0 DC 1.2
Rref vref0 ref 100k
Rfb vout ref 20k

* Behavioral comparator (LM339-equivalent)
Bcomp vout 0 V=5/(1+exp(-800*(V(sense)-V(ref))))

.tran 0 12 0 1m
.control
run
plot V(sense) V(ref) V(vout)
.endc
.end
